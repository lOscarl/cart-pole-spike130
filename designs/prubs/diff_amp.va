// importing libs

`include "discipline.h"

module diff_amp(
	output electrical out,
	input electrical in1,
	input electrical in2);

parameter real gain = 400;
parameter real vcc = 3;
parameter real offset = 1.5;

analog begin
	V(out) <+ offset + vcc / 2 *tanh( gain / vcc * 2 * V(in1,in2));
end
endmodule
